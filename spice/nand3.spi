*** SPICE deck for cell nand3{sch} from library proj2
*** Created on Sat Dec 27, 2025 22:02:41
*** Last revised on Wed May 06, 2026 23:21:29
*** Written on Wed May 06, 2026 23:21:33 by Electric VLSI Design System, version 9.08
*** Layout tech: mocmos, foundry MOSIS
*** UC SPICE *** , MIN_RESIST 4.0, MIN_CAPAC 0.1FF
*** Lambda Conversion ***
.opt scale=0.022U

* Model cards described in this file:
.include /Users/tmarhguy/Downloads/22nm_HP.pm

.global gnd vdd

*** TOP LEVEL CELL: nand3{sch}
Mnmos@2 net@11 b net@10 gnd N L=2 W=4
Mnmos@3 y a net@11 gnd N L=2 W=4
Mnmos@5 net@10 c gnd gnd N L=2 W=4
Mpmos@0 y a vdd vdd P L=2 W=4
Mpmos@1 y b vdd vdd P L=2 W=4
Mpmos@2 y c vdd vdd P L=2 W=4

* Spice Code nodes in cell cell 'nand3{sch}'
* nand3 unit test
Vdd vdd 0 DC 1.0
Cload y 0 2f
* Binary counter setup to test all 8 states
* Vc is shortened slightly so it falls before Va and Vb, isolating the worst-case rise!
Va a 0 PULSE(0 1.0 4n 10p 10p 3990p 8n)
Vb b 0 PULSE(0 1.0 2n 10p 10p 1990p 4n)
Vc c 0 PULSE(0 1.0 1n 10p 10p 700p 2n)
.control
tran 5p 9n
* tphl: Y falls when all inputs become 1.
* This happens at t=7ns when Vc has its 4th rise.
meas tran tphl trig v(c) val=0.5 rise=4 targ v(y) val=0.5 fall=1
* tplh: Y rises when Vc falls back to 0, while Va and Vb are still 1.
* This gives the worst-case single-PMOS rise. Happens at t=7.71ns (Vc's 4th fall).
meas tran tplh trig v(c) val=0.5 fall=4 targ v(y) val=0.5 rise=1
* --- Custom Terminal Output ---
echo " "
echo "========================================"
echo "       NAND3 Propagation Delays"
echo "========================================"
print tphl tplh
echo " "
set hcopydevtype=svg
hardcopy waveforms/nand3.svg v(a)+6 v(b)+4 v(c)+2 v(y) title 'nand3'
plot v(a)+6 v(b)+4 v(c)+2 v(y) title 'nand3'
.endc
.end
.END
