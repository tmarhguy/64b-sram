*** SPICE deck for cell sense_amp{sch} from library proj2
*** Created on Tue May 05, 2026 13:13:14
*** Last revised on Thu May 07, 2026 00:49:28
*** Written on Thu May 07, 2026 00:49:33 by Electric VLSI Design System, version 9.08
*** Layout tech: mocmos, foundry MOSIS
*** UC SPICE *** , MIN_RESIST 4.0, MIN_CAPAC 0.1FF
*** Lambda Conversion ***
.opt scale=0.022U

* Model cards described in this file:
.include /Users/tmarhguy/Downloads/22nm_HP.pm

.global gnd vdd

*** TOP LEVEL CELL: sense_amp{sch}
Mnmos@0 out outb node2 gnd N L=2 W=6
Mnmos@1 outb out node3 gnd N L=2 W=6
Mnmos@2 node2 bl node1 gnd N L=2 W=4
Mnmos@3 node3 blb node1 gnd N L=2 W=4
Mnmos@4 node1 SAE gnd gnd N L=2 W=8
Mpmos@0 vdd SAE out vdd P L=2 W=2
Mpmos@1 vdd outb out vdd P L=2 W=6
Mpmos@2 vdd out outb vdd P L=2 W=6
Mpmos@3 vdd SAE outb vdd P L=2 W=2

* Spice Code nodes in cell cell 'sense_amp{sch}'
* Sense Amp (SA) Unit Test
Vdd vdd 0 DC 1.0
Cload_out out 0 5f
Cload_outb outb 0 5f
* Bitline inputs (Pre-conditioned with 100mV differential)
Vbl bl 0 DC 1.0
Vblb blb 0 DC 0.9
* Sense Amp Enable (SAE) - fires at 1ns
Vsae SAE 0 PULSE(0 1.0 1n 10p 10p 1n 3n)
.control
tran 1p 3n
* Measure Decision Time: SAE rising to outb rising (correct polarity)
meas tran t_decision trig v(SAE) val=0.5 rise=1 targ v(outb) val=0.9 rise=1
* Also measure the falling output
meas tran t_decision_fall trig v(SAE) val=0.5 rise=1 targ v(out) val=0.1 fall=1
echo " "
echo "========================================"
echo "    SENSE AMP (100mV Differential)"
echo "========================================"
echo "Decision time (SAE -> outb high):"
print t_decision
echo "Decision time (SAE -> out low):"
print t_decision_fall
echo "========================================"
echo " "
set hcopydevtype=svg
hardcopy waveforms/sense_amp.svg v(SAE)+2 v(bl)+1 v(blb)+1 v(out) v(outb)-1 title 'Sense Amp'
plot v(SAE)+2 v(bl)+1 v(blb)+1 v(out) v(outb)-1 title 'Sense Amp'
.endc
.END
