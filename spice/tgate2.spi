*** SPICE deck for cell tgate2{sch} from library proj2
*** Created on Tue May 05, 2026 12:09:06
*** Last revised on Thu May 07, 2026 02:31:31
*** Written on Thu May 07, 2026 03:39:12 by Electric VLSI Design System, version 9.08
*** Layout tech: mocmos, foundry MOSIS
*** UC SPICE *** , MIN_RESIST 4.0, MIN_CAPAC 0.1FF
*** Lambda Conversion ***
.opt scale=0.022U

* Model cards described in this file:
.include /Users/tmarhguy/Downloads/22nm_HP.pm

.global gnd vdd

*** TOP LEVEL CELL: tgate2{sch}
Mnmos-4@0 in en out gnd N L=2 W=16
Mpmos-4@0 out en_b in vdd P L=2 W=16
.END
