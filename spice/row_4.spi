*** SPICE deck for cell row_4{sch} from library proj2
*** Created on Tue May 05, 2026 14:57:44
*** Last revised on Tue May 05, 2026 15:09:23
*** Written on Tue May 05, 2026 15:09:46 by Electric VLSI Design System, version 9.08
*** Layout tech: mocmos, foundry MOSIS
*** UC SPICE *** , MIN_RESIST 4.0, MIN_CAPAC 0.1FF
*** Lambda Conversion ***
.opt scale=0.022U

* Model cards described in this file:
.include /Users/tmarhguy/Downloads/22nm_HP.pm

*** SUBCIRCUIT proj2__sram_6t_cell FROM CELL sram_6t_cell{sch}
.SUBCKT proj2__sram_6t_cell bl blb wl
** GLOBAL gnd
** GLOBAL vdd
Mnmos@3 net@53 net@48 gnd gnd N L=2 W=2
Mnmos@4 net@48 net@53 gnd gnd N L=2 W=2
Mnmos@5 bl wl net@48 gnd N L=2 W=1
Mnmos@6 blb wl net@53 gnd N L=2 W=1
Mpmos@0 net@53 net@48 vdd vdd P L=2 W=1
Mpmos@1 net@48 net@53 vdd vdd P L=2 W=1
.ENDS proj2__sram_6t_cell

.global gnd vdd

*** TOP LEVEL CELL: row_4{sch}
Xsram_6t_@4 BL_0 BLB_0 WL proj2__sram_6t_cell
Xsram_6t_@5 BL_1 BLB_1 WL proj2__sram_6t_cell
Xsram_6t_@6 BL_2 BLB_2 WL proj2__sram_6t_cell
Xsram_6t_@7 BL_3 BLB_3 WL proj2__sram_6t_cell
.END
