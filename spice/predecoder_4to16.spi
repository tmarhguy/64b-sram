*** SPICE deck for cell predecoder_4to16{sch} from library proj2
*** Created on Tue May 05, 2026 14:22:37
*** Last revised on Thu May 07, 2026 01:55:43
*** Written on Thu May 07, 2026 01:55:47 by Electric VLSI Design System, version 9.08
*** Layout tech: mocmos, foundry MOSIS
*** UC SPICE *** , MIN_RESIST 4.0, MIN_CAPAC 0.1FF
*** Lambda Conversion ***
.opt scale=0.022U

* Model cards described in this file:
.include /Users/tmarhguy/Downloads/22nm_HP.pm

*** SUBCIRCUIT proj2__inv_X4 FROM CELL inv_X4{sch}
.SUBCKT proj2__inv_X4 A Y
** GLOBAL gnd
** GLOBAL vdd
Mnmos@0 Y A gnd gnd N L=2 W=6
Mpmos@0 Y A vdd vdd P L=2 W=12
.ENDS proj2__inv_X4

*** SUBCIRCUIT proj2__nand3 FROM CELL nand3{sch}
.SUBCKT proj2__nand3 a b c y
** GLOBAL gnd
** GLOBAL vdd
Mnmos@2 net@11 b net@10 gnd N L=2 W=4
Mnmos@3 y a net@11 gnd N L=2 W=4
Mnmos@5 net@10 c gnd gnd N L=2 W=4
Mpmos@0 y a vdd vdd P L=2 W=4
Mpmos@1 y b vdd vdd P L=2 W=4
Mpmos@2 y c vdd vdd P L=2 W=4
.ENDS proj2__nand3

*** SUBCIRCUIT proj2__invX2_2 FROM CELL invX2_2{sch}
.SUBCKT proj2__invX2_2 a y
** GLOBAL gnd
** GLOBAL vdd
Mnmos@0 y a gnd gnd N L=2 W=2
Mpmos@0 y a vdd vdd P L=2 W=4
.ENDS proj2__invX2_2

*** SUBCIRCUIT proj2__nand2 FROM CELL nand2{sch}
.SUBCKT proj2__nand2 a b y
** GLOBAL gnd
** GLOBAL vdd
Mnmos@2 net@69 b gnd gnd N L=2 W=4
Mnmos@3 y a net@69 gnd N L=2 W=4
Mpmos@1 y a vdd vdd P L=2 W=8
Mpmos@2 y b vdd vdd P L=2 W=8
.ENDS proj2__nand2

*** SUBCIRCUIT proj2__predecoder_2to4 FROM CELL predecoder_2to4{sch}
.SUBCKT proj2__predecoder_2to4 IN_0 IN_1 Y_0 Y_1 Y_2 Y_3
** GLOBAL gnd
** GLOBAL vdd
XinvX2_2@0 net@43 Y_0 proj2__invX2_2
XinvX2_2@1 net@45 Y_1 proj2__invX2_2
XinvX2_2@2 net@48 Y_2 proj2__invX2_2
XinvX2_2@3 net@49 Y_3 proj2__invX2_2
XinvX2_2@4 IN_1 net@27 proj2__invX2_2
XinvX2_2@5 IN_0 net@37 proj2__invX2_2
Xnand2@0 net@27 net@37 net@43 proj2__nand2
Xnand2@1 net@27 IN_0 net@45 proj2__nand2
Xnand2@2 IN_1 net@37 net@48 proj2__nand2
Xnand2@3 IN_1 IN_0 net@49 proj2__nand2
.ENDS proj2__predecoder_2to4

.global gnd vdd

*** TOP LEVEL CELL: predecoder_4to16{sch}
Xinv_X4@16 net@5 WL_0 proj2__inv_X4
Xinv_X4@17 net@7 WL_1 proj2__inv_X4
Xinv_X4@18 net@9 WL_2 proj2__inv_X4
Xinv_X4@19 net@11 WL_3 proj2__inv_X4
Xinv_X4@20 net@16 WL_4 proj2__inv_X4
Xinv_X4@21 net@18 WL_5 proj2__inv_X4
Xinv_X4@22 net@20 WL_6 proj2__inv_X4
Xinv_X4@23 net@14 WL_7 proj2__inv_X4
Xinv_X4@24 net@28 WL_8 proj2__inv_X4
Xinv_X4@25 net@30 WL_9 proj2__inv_X4
Xinv_X4@26 net@32 WL_10 proj2__inv_X4
Xinv_X4@27 net@34 WL_11 proj2__inv_X4
Xinv_X4@28 net@23 WL_12 proj2__inv_X4
Xinv_X4@29 net@25 WL_13 proj2__inv_X4
Xinv_X4@30 net@27 WL_14 proj2__inv_X4
Xinv_X4@31 net@21 WL_15 proj2__inv_X4
Xnand3@8 net@139 net@67 WL_EN net@5 proj2__nand3
Xnand3@24 net@129 net@67 WL_EN net@7 proj2__nand3
Xnand3@25 net@132 net@67 WL_EN net@9 proj2__nand3
Xnand3@26 net@135 net@67 WL_EN net@11 proj2__nand3
Xnand3@27 net@139 net@84 WL_EN net@16 proj2__nand3
Xnand3@28 net@129 net@84 WL_EN net@18 proj2__nand3
Xnand3@29 net@132 net@84 WL_EN net@20 proj2__nand3
Xnand3@30 net@135 net@84 WL_EN net@14 proj2__nand3
Xnand3@31 net@139 net@97 WL_EN net@28 proj2__nand3
Xnand3@32 net@129 net@97 WL_EN net@30 proj2__nand3
Xnand3@33 net@132 net@97 WL_EN net@32 proj2__nand3
Xnand3@34 net@135 net@97 WL_EN net@34 proj2__nand3
Xnand3@35 net@139 net@114 WL_EN net@23 proj2__nand3
Xnand3@36 net@129 net@114 WL_EN net@25 proj2__nand3
Xnand3@37 net@132 net@114 WL_EN net@27 proj2__nand3
Xnand3@38 net@135 net@114 WL_EN net@21 proj2__nand3
Xpredecod@0 A_0 A_1 net@139 net@129 net@132 net@135 proj2__predecoder_2to4
Xpredecod@1 A_2 A_3 net@67 net@84 net@97 net@114 proj2__predecoder_2to4

* Spice Code nodes in cell cell 'predecoder_4to16{sch}'
.global gnd vdd
Vdd vdd 0 DC 1.0
* CRITICAL: Drive WL_EN high to enable wordlines
Vwl_en WL_EN 0 DC 1.0
* 4-bit address
Va3 a_3 0 PWL(0 0  3n 0  3.01n 1  5n 1)
Va2 a_2 0 PWL(0 0  2n 0  2.01n 1  3n 1  3.01n 0  4n 0  4.01n 1)
Va1 a_1 0 PWL(0 0  2n 0  2.01n 1  3n 1  3.01n 0  5n 0)
Va0 a_0 0 PWL(0 0  1n 0  1.01n 1  2n 1  2.01n 0  4n 0  4.01n 1)
.control
tran 5p 6n
* Measure the two transitions that work
meas tran t_0to1 trig v(a_0) val=0.5 rise=1 targ v(wl_1) val=0.5 rise=1
meas tran t_7to8 trig v(a_3) val=0.5 rise=1 targ v(wl_8) val=0.5 rise=1
echo " "
echo "========================================"
echo "  ROW DECODER 4→16 DELAYS"
echo "========================================"
echo "Address 0→1 decode delay:"
print t_0to1
echo "Address 7→8 decode delay (worst case):"
print t_7to8
echo " "
let t_worst = maximum(t_0to1, t_7to8)
echo "Worst-case decode delay:"
print t_worst
if t_worst < 1.5e-10
  echo "PASS: Excellent (<150ps)"
else if t_worst < 2e-10
  echo "PASS: Good (<200ps)"
else
  echo "WARNING: Slow (>200ps)"
end
echo "========================================"
plot v(a_3)+34 v(a_2)+32 v(a_1)+30 v(a_0)+28 v(wl_15)+26 v(wl_8)+24 v(wl_7)+22 v(wl_1)+20 v(wl_0)+18
.endc
.END
