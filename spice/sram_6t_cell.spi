*** SPICE deck for cell sram_6t_cell{sch} from library proj2
*** Created on Fri Apr 10, 2026 18:02:21
*** Last revised on Thu May 07, 2026 03:38:57
*** Written on Fri May 08, 2026 19:13:27 by Electric VLSI Design System, version 9.08
*** Layout tech: mocmos, foundry MOSIS
*** UC SPICE *** , MIN_RESIST 4.0, MIN_CAPAC 0.1FF
*** Lambda Conversion ***
.opt scale=0.022U

* Model cards described in this file:
.include /Users/tmarhguy/Downloads/22nm_HP.pm

.global gnd vdd

*** TOP LEVEL CELL: sram_6t_cell{sch}
Mnmos@3 qb q gnd gnd N L=2 W=2
Mnmos@4 q qb gnd gnd N L=2 W=2
Mnmos@5 bl wl q gnd N L=2 W=1
Mnmos@6 blb wl qb gnd N L=2 W=1
Mpmos@0 qb q vdd vdd P L=2 W=1
Mpmos@1 q qb vdd vdd P L=2 W=1
.END
