*** SPICE deck for cell top{sch} from library proj2
*** Created on Tue May 05, 2026 21:19:42
*** Last revised on Thu May 07, 2026 04:51:06
*** Written on Fri May 08, 2026 18:47:08 by Electric VLSI Design System, version 9.08
*** Layout tech: mocmos, foundry MOSIS
*** UC SPICE *** , MIN_RESIST 4.0, MIN_CAPAC 0.1FF
*** Lambda Conversion ***
.opt scale=0.022U

* Model cards described in this file:
.include /Users/tmarhguy/Downloads/22nm_HP.pm

*** SUBCIRCUIT proj2__invX2_2 FROM CELL invX2_2{sch}
.SUBCKT proj2__invX2_2 a y
** GLOBAL gnd
** GLOBAL vdd
Mnmos@0 y a gnd gnd N L=1 W=3
Mpmos@0 y a vdd vdd P L=1 W=6
.ENDS proj2__invX2_2

*** SUBCIRCUIT proj2__inv_X5 FROM CELL inv_X5{sch}
.SUBCKT proj2__inv_X5 A Y
** GLOBAL gnd
** GLOBAL vdd
Mnmos@0 Y A gnd gnd N L=1 W=14
Mpmos@0 Y A vdd vdd P L=1 W=28
.ENDS proj2__inv_X5

*** SUBCIRCUIT proj2__tgate2 FROM CELL tgate2{sch}
.SUBCKT proj2__tgate2 en en_b in out
** GLOBAL gnd
** GLOBAL vdd
Mnmos-4@0 in en out gnd N L=1 W=3
Mpmos-4@0 out en_b in vdd P L=1 W=3
.ENDS proj2__tgate2

*** SUBCIRCUIT proj2__dff FROM CELL dff{sch}
.SUBCKT proj2__dff clk d q
** GLOBAL gnd
** GLOBAL vdd
XinvX2_2@3 node1 node2 proj2__invX2_2
XinvX2_2@4 clk clk_b proj2__invX2_2
XinvX2_2@6 q netfb2 proj2__invX2_2
XinvX2_2@7 node2 netfb proj2__invX2_2
Xinv_X5@0 node3 q proj2__inv_X5
Xtgate2@0 clk_b clk d node1 proj2__tgate2
Xtgate2@1 clk clk_b node2 node3 proj2__tgate2
Xtgate2@2 clk_b clk netfb2 node3 proj2__tgate2
Xtgate2@3 clk clk_b netfb node1 proj2__tgate2
.ENDS proj2__dff

*** SUBCIRCUIT proj2__inv_X4 FROM CELL inv_X4{sch}
.SUBCKT proj2__inv_X4 A Y
** GLOBAL gnd
** GLOBAL vdd
Mnmos@0 Y A gnd gnd N L=1 W=6
Mpmos@0 Y A vdd vdd P L=1 W=14
.ENDS proj2__inv_X4

*** SUBCIRCUIT proj2__inv FROM CELL inv{sch}
.SUBCKT proj2__inv a y
** GLOBAL gnd
** GLOBAL vdd
Mnmos@0 y a gnd gnd N L=1 W=1
Mpmos@0 y a vdd vdd P L=1 W=1
.ENDS proj2__inv

*** SUBCIRCUIT proj2__inv_X8 FROM CELL inv_X8{sch}
.SUBCKT proj2__inv_X8 A Y
** GLOBAL gnd
** GLOBAL vdd
Mnmos@0 Y A gnd gnd N L=1 W=12
Mpmos@0 Y A vdd vdd P L=1 W=28
.ENDS proj2__inv_X8

*** SUBCIRCUIT proj2__nor2 FROM CELL nor2{sch}
.SUBCKT proj2__nor2 a b y
** GLOBAL gnd
** GLOBAL vdd
Mnmos@0 y a gnd gnd N L=1 W=2
Mnmos@1 y b gnd gnd N L=1 W=2
Mpmos@0 net@0 b vdd vdd P L=1 W=2
Mpmos@1 y a net@0 vdd P L=1 W=2
.ENDS proj2__nor2

*** SUBCIRCUIT proj2__clock-gen-2phase FROM CELL clock-gen-2phase{sch}
.SUBCKT proj2__clock-gen-2phase in phi1_b phi2 phi2_b
** GLOBAL gnd
** GLOBAL vdd
Xinv@0 in net@1 proj2__inv_X4
Xinv@1 in net@16 proj2__inv_X4
Xinv@2 net@16 net@17 proj2__inv_X4
Xinv@3 net@12 net@35 proj2__inv
Xinv@4 net@8 net@34 proj2__inv
Xinv_X4@1 net@12 net@23 proj2__inv_X4
Xinv_X4@2 net@35 net@32 proj2__inv_X4
Xinv_X4@3 net@34 net@33 proj2__inv_X4
Xinv_X8@1 net@23 phi2 proj2__inv_X8
Xinv_X8@2 net@32 phi2_b proj2__inv_X8
Xinv_X8@3 net@33 phi1_b proj2__inv_X8
Xnor2@0 net@1 net@8 net@12 proj2__nor2
Xnor2@1 net@12 net@17 net@8 proj2__nor2
.ENDS proj2__clock-gen-2phase

*** SUBCIRCUIT proj2__tgate FROM CELL tgate{sch}
.SUBCKT proj2__tgate en en_b in out
** GLOBAL gnd
** GLOBAL vdd
Mnmos-4@0 in en out gnd N L=1 W=6
Mpmos-4@0 out en_b in vdd P L=1 W=8
.ENDS proj2__tgate

*** SUBCIRCUIT proj2__output_latch FROM CELL output_latch{sch}
.SUBCKT proj2__output_latch D_out phi2 phi2_b SO
** GLOBAL gnd
** GLOBAL vdd
Xinv_X4@0 net@87 D_out proj2__inv_X4
Xinv_X4@4 net@54 net@76 proj2__inv_X4
Xinv_X4@5 net@76 net@87 proj2__inv_X4
Xinv_X4@6 inv_X4@6_A inv_X4@6_Y proj2__inv_X4
Xinv_X4@7 net@76 net@90 proj2__inv_X4
Xtgate@0 phi2 phi2_b SO net@54 proj2__tgate
Xtgate@1 phi2_b phi2 net@90 net@54 proj2__tgate
.ENDS proj2__output_latch

*** SUBCIRCUIT proj2__precharge_eq FROM CELL precharge_eq{sch}
.SUBCKT proj2__precharge_eq BL BLB PCH_b
** GLOBAL vdd
Mpmos-4@0 BL PCH_b BLB vdd P L=1 W=2
Mpmos-4@1 BLB PCH_b vdd vdd P L=1 W=6
Mpmos-4@2 BL PCH_b vdd vdd P L=1 W=6
.ENDS proj2__precharge_eq

*** SUBCIRCUIT proj2__sense_amp FROM CELL sense_amp{sch}
.SUBCKT proj2__sense_amp bl blb out outb SAE
** GLOBAL gnd
** GLOBAL vdd
Mnmos@0 out outb node2 gnd N L=1 W=8
Mnmos@1 outb out node3 gnd N L=1 W=8
Mnmos@2 node2 bl node1 gnd N L=1 W=6
Mnmos@3 node3 blb node1 gnd N L=1 W=6
Mnmos@4 node1 SAE gnd gnd N L=1 W=10
Mpmos@0 vdd SAE out vdd P L=1 W=3
Mpmos@1 vdd outb out vdd P L=1 W=8
Mpmos@2 vdd out outb vdd P L=1 W=8
Mpmos@3 vdd SAE outb vdd P L=1 W=3
.ENDS proj2__sense_amp

*** SUBCIRCUIT proj2__sram_6t_cell FROM CELL sram_6t_cell{sch}
.SUBCKT proj2__sram_6t_cell bl blb wl
** GLOBAL gnd
** GLOBAL vdd
Mnmos@3 qb q gnd gnd N L=2 W=2
Mnmos@4 q qb gnd gnd N L=2 W=2
Mnmos@5 bl wl q gnd N L=2 W=1
Mnmos@6 blb wl qb gnd N L=2 W=1
Mpmos@0 qb q vdd vdd P L=2 W=1
Mpmos@1 q qb vdd vdd P L=2 W=1
.ENDS proj2__sram_6t_cell

*** SUBCIRCUIT proj2__invX2 FROM CELL invX2{sch}
.SUBCKT proj2__invX2 a y
** GLOBAL gnd
** GLOBAL vdd
Mnmos@0 y a gnd gnd N L=1 W=1
Mpmos@0 y a vdd vdd P L=1 W=1
.ENDS proj2__invX2

*** SUBCIRCUIT proj2__tristate_inv FROM CELL tristate_inv{sch}
.SUBCKT proj2__tristate_inv en en_b x y
** GLOBAL gnd
** GLOBAL vdd
Mnmos@0 y en net@2 gnd N L=2 W=8
Mnmos@1 net@2 x gnd gnd N L=2 W=8
Mpmos@0 vdd x net@0 vdd P L=2 W=16
Mpmos@1 net@0 en_b y vdd P L=2 W=16
.ENDS proj2__tristate_inv

*** SUBCIRCUIT proj2__write_driver FROM CELL write_driver{sch}
.SUBCKT proj2__write_driver bl blb din wd_en
** GLOBAL gnd
** GLOBAL vdd
XinvX2@0 din net@25 proj2__invX2
XinvX2@2 wd_en net@35 proj2__invX2
Xtristate@3 wd_en net@35 net@25 bl proj2__tristate_inv
Xtristate@4 wd_en net@35 din blb proj2__tristate_inv
.ENDS proj2__write_driver

*** SUBCIRCUIT proj2__column_slice FROM CELL column_slice{sch}
.SUBCKT proj2__column_slice D_OUT din PCH_b phi2 phi2_b SAE wd_en WL_0 WL_1 WL_10 WL_11 WL_12 WL_13 WL_14 WL_15 WL_2 WL_3 WL_4 WL_5 WL_6 WL_7 WL_8 WL_9
** GLOBAL gnd
** GLOBAL vdd
Xoutput_l@0 D_OUT phi2 phi2_b net@107 proj2__output_latch
Xprecharg@0 net@32 net@35 PCH_b proj2__precharge_eq
Xsense_am@0 net@32 net@35 net@107 sense_am@0_outb SAE proj2__sense_amp
Xsram_6t_@0 net@32 net@35 WL_0 proj2__sram_6t_cell
Xsram_6t_@2 net@32 net@35 WL_1 proj2__sram_6t_cell
Xsram_6t_@3 net@32 net@35 WL_2 proj2__sram_6t_cell
Xsram_6t_@4 net@32 net@35 WL_3 proj2__sram_6t_cell
Xsram_6t_@5 net@32 net@35 WL_4 proj2__sram_6t_cell
Xsram_6t_@6 net@32 net@35 WL_5 proj2__sram_6t_cell
Xsram_6t_@7 net@32 net@35 WL_6 proj2__sram_6t_cell
Xsram_6t_@8 net@32 net@35 WL_7 proj2__sram_6t_cell
Xsram_6t_@17 net@32 net@35 WL_8 proj2__sram_6t_cell
Xsram_6t_@18 net@32 net@35 WL_9 proj2__sram_6t_cell
Xsram_6t_@19 net@32 net@35 WL_10 proj2__sram_6t_cell
Xsram_6t_@20 net@32 net@35 WL_11 proj2__sram_6t_cell
Xsram_6t_@21 net@32 net@35 WL_12 proj2__sram_6t_cell
Xsram_6t_@22 net@32 net@35 WL_13 proj2__sram_6t_cell
Xsram_6t_@23 net@32 net@35 WL_14 proj2__sram_6t_cell
Xsram_6t_@24 net@32 net@35 WL_15 proj2__sram_6t_cell
Xwrite_dr@0 net@32 net@35 din wd_en proj2__write_driver
.ENDS proj2__column_slice

*** SUBCIRCUIT proj2__nand2 FROM CELL nand2{sch}
.SUBCKT proj2__nand2 a b y
** GLOBAL gnd
** GLOBAL vdd
Mnmos@2 net@69 b gnd gnd N L=1 W=6
Mnmos@3 y a net@69 gnd N L=1 W=6
Mpmos@1 y a vdd vdd P L=1 W=10
Mpmos@2 y b vdd vdd P L=1 W=10
.ENDS proj2__nand2

*** SUBCIRCUIT proj2__nand3 FROM CELL nand3{sch}
.SUBCKT proj2__nand3 a b c y
** GLOBAL gnd
** GLOBAL vdd
Mnmos@2 net@11 b net@10 gnd N L=1 W=8
Mnmos@3 y a net@11 gnd N L=1 W=8
Mnmos@5 net@10 c gnd gnd N L=1 W=8
Mpmos@0 y a vdd vdd P L=1 W=6
Mpmos@1 y b vdd vdd P L=1 W=6
Mpmos@2 y c vdd vdd P L=1 W=6
.ENDS proj2__nand3

*** SUBCIRCUIT proj2__predecoder_2to4 FROM CELL predecoder_2to4{sch}
.SUBCKT proj2__predecoder_2to4 IN_0 IN_1 Y_0 Y_1 Y_2 Y_3
** GLOBAL gnd
** GLOBAL vdd
XinvX2_2@0 net@43 Y_0 proj2__invX2_2
XinvX2_2@1 net@45 Y_1 proj2__invX2_2
XinvX2_2@2 net@48 Y_2 proj2__invX2_2
XinvX2_2@3 net@82 Y_3 proj2__invX2_2
XinvX2_2@4 IN_1 net@27 proj2__invX2_2
XinvX2_2@5 IN_0 net@37 proj2__invX2_2
Xnand2@0 net@27 net@37 net@43 proj2__nand2
Xnand2@1 net@27 IN_0 net@45 proj2__nand2
Xnand2@2 IN_1 net@37 net@48 proj2__nand2
Xnand2@3 IN_1 IN_0 net@82 proj2__nand2
.ENDS proj2__predecoder_2to4

*** SUBCIRCUIT proj2__predecoder_4to16 FROM CELL predecoder_4to16{sch}
.SUBCKT proj2__predecoder_4to16 A_0 A_1 A_2 A_3 WL_0 WL_1 WL_10 WL_11 WL_12 WL_13 WL_14 WL_15 WL_2 WL_3 WL_4 WL_5 WL_6 WL_7 WL_8 WL_9 WL_EN
** GLOBAL gnd
** GLOBAL vdd
Xinv_X4@16 net@5 WL_0 proj2__inv_X4
Xinv_X4@17 net@7 WL_1 proj2__inv_X4
Xinv_X4@18 net@9 WL_2 proj2__inv_X4
Xinv_X4@19 net@11 WL_3 proj2__inv_X4
Xinv_X4@20 net@16 WL_4 proj2__inv_X4
Xinv_X4@21 net@18 WL_5 proj2__inv_X4
Xinv_X4@22 net@20 WL_6 proj2__inv_X4
Xinv_X4@23 net@14 WL_7 proj2__inv_X4
Xinv_X4@24 net@28 WL_8 proj2__inv_X4
Xinv_X4@25 net@30 WL_9 proj2__inv_X4
Xinv_X4@26 net@32 WL_10 proj2__inv_X4
Xinv_X4@27 net@34 WL_11 proj2__inv_X4
Xinv_X4@28 net@23 WL_12 proj2__inv_X4
Xinv_X4@29 net@25 WL_13 proj2__inv_X4
Xinv_X4@30 net@27 WL_14 proj2__inv_X4
Xinv_X4@31 net@21 WL_15 proj2__inv_X4
Xnand3@8 net@139 net@67 WL_EN net@5 proj2__nand3
Xnand3@24 net@129 net@67 WL_EN net@7 proj2__nand3
Xnand3@25 net@132 net@67 WL_EN net@9 proj2__nand3
Xnand3@26 net@135 net@67 WL_EN net@11 proj2__nand3
Xnand3@27 net@139 net@84 WL_EN net@16 proj2__nand3
Xnand3@28 net@129 net@84 WL_EN net@18 proj2__nand3
Xnand3@29 net@132 net@84 WL_EN net@20 proj2__nand3
Xnand3@30 net@135 net@84 WL_EN net@14 proj2__nand3
Xnand3@31 net@139 net@97 WL_EN net@28 proj2__nand3
Xnand3@32 net@129 net@97 WL_EN net@30 proj2__nand3
Xnand3@33 net@132 net@97 WL_EN net@32 proj2__nand3
Xnand3@34 net@135 net@97 WL_EN net@34 proj2__nand3
Xnand3@35 net@139 net@114 WL_EN net@23 proj2__nand3
Xnand3@36 net@129 net@114 WL_EN net@25 proj2__nand3
Xnand3@37 net@132 net@114 WL_EN net@27 proj2__nand3
Xnand3@38 net@135 net@114 WL_EN net@21 proj2__nand3
Xpredecod@0 A_0 A_1 net@139 net@129 net@132 net@135 proj2__predecoder_2to4
Xpredecod@1 A_2 A_3 net@67 net@84 net@97 net@114 proj2__predecoder_2to4
.ENDS proj2__predecoder_4to16

*** SUBCIRCUIT proj2__dummy_bitcell FROM CELL dummy_bitcell{sch}
.SUBCKT proj2__dummy_bitcell BL BLB WL
** GLOBAL gnd
** GLOBAL vdd
Mnmos@0 vdd gnd gnd gnd N L=2 W=2
Mnmos@1 gnd vdd gnd gnd N L=2 W=2
Mnmos@2 BL WL gnd gnd N L=2 W=1
Mnmos@3 BLB WL vdd gnd N L=2 W=1
Mpmos@0 vdd gnd vdd vdd P L=2 W=1
Mpmos@1 gnd vdd vdd vdd P L=2 W=1
.ENDS proj2__dummy_bitcell

*** SUBCIRCUIT proj2__replica_column FROM CELL replica_column{sch}
.SUBCKT proj2__replica_column PCH_b SAE WL_0 WL_1 WL_10 WL_11 WL_12 WL_13 WL_14 WL_15 WL_2 WL_3 WL_4 WL_5 WL_6 WL_7 WL_8 WL_9
** GLOBAL gnd
** GLOBAL vdd
Mnmos@0 net@117 net@20 gnd gnd N L=1 W=4
Mpmos@0 vdd PCH_b net@20 vdd P L=1 W=4
Mpmos@1 vdd net@20 net@117 vdd P L=1 W=2
Xdummy_bi@18 net@20 net@18 WL_0 proj2__dummy_bitcell
Xdummy_bi@19 net@20 net@18 WL_1 proj2__dummy_bitcell
Xdummy_bi@20 net@20 net@18 WL_2 proj2__dummy_bitcell
Xdummy_bi@21 net@20 net@18 WL_3 proj2__dummy_bitcell
Xdummy_bi@22 net@20 net@18 WL_4 proj2__dummy_bitcell
Xdummy_bi@23 net@20 net@18 WL_5 proj2__dummy_bitcell
Xdummy_bi@24 net@20 net@18 WL_6 proj2__dummy_bitcell
Xdummy_bi@25 net@20 net@18 WL_7 proj2__dummy_bitcell
Xdummy_bi@26 net@20 net@18 WL_8 proj2__dummy_bitcell
Xdummy_bi@27 net@20 net@18 WL_9 proj2__dummy_bitcell
Xdummy_bi@28 net@20 net@18 WL_10 proj2__dummy_bitcell
Xdummy_bi@29 net@20 net@18 WL_11 proj2__dummy_bitcell
Xdummy_bi@30 net@20 net@18 WL_12 proj2__dummy_bitcell
Xdummy_bi@31 net@20 net@18 WL_13 proj2__dummy_bitcell
Xdummy_bi@32 net@20 net@18 WL_14 proj2__dummy_bitcell
Xdummy_bi@33 net@20 net@18 WL_15 proj2__dummy_bitcell
XinvX2@0 net@117 net@125 proj2__invX2
XinvX2@1 net@125 SAE proj2__invX2
.ENDS proj2__replica_column

.global gnd vdd

*** TOP LEVEL CELL: top{sch}
XWE_q CLK WE net@80 proj2__dff
Xclock-ge@0 CLK PCH_b WL_EN phi2_b proj2__clock-gen-2phase
Xcolumn_s@2 Dout_0 Din_q_0 PCH_b WL_EN phi2_b SAE WD_EN WL_0 WL_1 WL_10 WL_11 WL_12 WL_13 WL_14 WL_15 WL_2 WL_3 WL_4 WL_5 WL_6 WL_7 WL_8 WL_9 proj2__column_slice
Xcolumn_s@3 Dout_1 Din_q_1 PCH_b WL_EN phi2_b SAE WD_EN WL_0 WL_1 WL_10 WL_11 WL_12 WL_13 WL_14 WL_15 WL_2 WL_3 WL_4 WL_5 WL_6 WL_7 WL_8 WL_9 proj2__column_slice
Xcolumn_s@4 Dout_2 Din_q_2 PCH_b WL_EN phi2_b SAE WD_EN WL_0 WL_1 WL_10 WL_11 WL_12 WL_13 WL_14 WL_15 WL_2 WL_3 WL_4 WL_5 WL_6 WL_7 WL_8 WL_9 proj2__column_slice
Xcolumn_s@5 Dout_3 Din_q_3 PCH_b WL_EN phi2_b SAE WD_EN WL_0 WL_1 WL_10 WL_11 WL_12 WL_13 WL_14 WL_15 WL_2 WL_3 WL_4 WL_5 WL_6 WL_7 WL_8 WL_9 proj2__column_slice
Xdff@12 CLK A_0 A_q_0 proj2__dff
Xdff@16 CLK A_1 A_q_1 proj2__dff
Xdff@17 CLK A_2 A_q_2 proj2__dff
Xdff@18 CLK A_3 A_q_3 proj2__dff
Xdff@19 CLK Din_0 Din_q_0 proj2__dff
Xdff@20 CLK Din_1 Din_q_1 proj2__dff
Xdff@21 CLK Din_2 Din_q_2 proj2__dff
Xdff@22 CLK Din_3 Din_q_3 proj2__dff
Xinv_X4@0 net@79 WD_EN proj2__inv_X4
Xnand2@0 net@80 WL_EN net@79 proj2__nand2
Xpredecod@0 A_q_0 A_q_1 A_q_2 A_q_3 WL_0 WL_1 WL_10 WL_11 WL_12 WL_13 WL_14 WL_15 WL_2 WL_3 WL_4 WL_5 WL_6 WL_7 WL_8 WL_9 WL_EN proj2__predecoder_4to16
Xreplica_@0 PCH_b SAE WL_0 WL_1 WL_10 WL_11 WL_12 WL_13 WL_14 WL_15 WL_2 WL_3 WL_4 WL_5 WL_6 WL_7 WL_8 WL_9 proj2__replica_column

* Spice Code nodes in cell cell 'top{sch}'
* ============================================================================
* 16x4 SRAM FUNCTIONAL VALIDATION
* ============================================================================
* Test sequence:
* 1) Write 0x5 to address 0
* 2) Write 0xA to address 1
* 3) Read address 0 (expect 0x5)
* 4) Read address 1 (expect 0xA)
* 5) Write 0xF to address 2 (additional stress)
* ============================================================================
.global gnd vdd
Vdd vdd 0 DC 1.0
* Clock: 500 MHz (2 ns period)
Vclk CLK 0 PULSE(0 1.0 100p 10p 10p 990p 2n)
* Address sequence:
* 0-2ns: addr=0
* 2-4ns: addr=1
* 4-6ns: addr=0 (read)
* 6-8ns: addr=1 (read)
* 8-10ns: addr=2
Va3 A_3 0 PWL(0 0  20n 0)
Va2 A_2 0 PWL(0 0  8n 0  8.01n 1  20n 1)
Va1 A_1 0 PWL(0 0  8n 0  8.01n 1  20n 1)
Va0 A_0 0 PWL(0 0  2n 0  2.01n 1  4n 1  4.01n 0  6n 0  6.01n 1  8n 1  8.01n 0  20n 0)
* Data sequence:
* 0-2ns: 0x5 (0101)
* 2-8ns: 0xA (1010)
* 8-10ns: 0xF (1111)
Vd3 Din_3 0 PWL(0 0  2n 0  2.01n 1  8n 1  8.01n 1  20n 1)
Vd2 Din_2 0 PWL(0 1  2n 1  2.01n 0  8n 0  8.01n 1  20n 1)
Vd1 Din_1 0 PWL(0 0  2n 0  2.01n 1  8n 1  8.01n 1  20n 1)
Vd0 Din_0 0 PWL(0 1  2n 1  2.01n 0  8n 0  8.01n 1  20n 1)
* Write enable:
* High during writes, low during read window
Vwe WE 0 PWL(0 1  3.6n 1  3.61n 0  8n 0  8.01n 1  20n 1)
.control
tran 10p 12n
echo " "
echo "========================================================================"
echo "                    16x4 SRAM FUNCTIONAL VALIDATION"
echo "========================================================================"
echo "Write phase: 0-4 ns"
echo "Read phase : 4-8 ns"
echo "Extra write: 8-10 ns"
echo " "
* Readback sampling points
meas tran D0_at_5ns find v(Dout_0) at=5n
meas tran D1_at_5ns find v(Dout_1) at=5n
meas tran D2_at_5ns find v(Dout_2) at=5n
meas tran D3_at_5ns find v(Dout_3) at=5n
meas tran D0_at_7ns find v(Dout_0) at=7n
meas tran D1_at_7ns find v(Dout_1) at=7n
meas tran D2_at_7ns find v(Dout_2) at=7n
meas tran D3_at_7ns find v(Dout_3) at=7n
* Timing metric: CLK-to-Dout (read of address 0)
meas tran t_clk_to_dout trig v(CLK) val=0.5 rise=3 targ v(Dout_0) val=0.5 cross=1 td=4n
* Power metric: average supply current over full run
meas tran iavg_vdd avg i(Vdd) from=0n to=12n
let pavg_mw = -iavg_vdd * 1.0 * 1e3
* Convert sampled outputs to hexadecimal-equivalent values
let hex_5ns = D3_at_5ns*8 + D2_at_5ns*4 + D1_at_5ns*2 + D0_at_5ns
let hex_7ns = D3_at_7ns*8 + D2_at_7ns*4 + D1_at_7ns*2 + D0_at_7ns
echo "========================================================================"
echo "Readback @5 ns (expect 0x5 = 0101)"
echo "========================================================================"
print D3_at_5ns D2_at_5ns D1_at_5ns D0_at_5ns
print hex_5ns
echo "========================================================================"
echo "Readback @7 ns (expect 0xA = 1010)"
echo "========================================================================"
print D3_at_7ns D2_at_7ns D1_at_7ns D0_at_7ns
print hex_7ns
echo "========================================================================"
echo "Performance Metrics"
echo "========================================================================"
print t_clk_to_dout
print iavg_vdd
print pavg_mw
let f_eq_ghz = 1e-9 / t_clk_to_dout
print f_eq_ghz
echo "========================================================================"
echo "Validation Status"
echo "========================================================================"
if abs(hex_5ns - 5) < 0.5
    echo "Address 0 readback: PASS"
else
    echo "Address 0 readback: FAIL"
end
if abs(hex_7ns - 10) < 0.5
    echo "Address 1 readback: PASS"
else
    echo "Address 1 readback: FAIL"
end
if t_clk_to_dout > 0
    echo "Timing measurement: VALID"
else
    echo "Timing measurement: INVALID"
end
echo "========================================================================"
echo " "
set hcopydevtype=svg
hardcopy waveforms/sram_full_validation.svg v(CLK)+12 v(WE)+10 v(A_1)+8 v(A_0)+6 v(Din_0)+4 v(Dout_0)+2 v(Dout_1) v(Dout_2)-2 v(Dout_3)-4 title 'SRAM Full Validation'
plot v(CLK)+12 v(WE)+10 v(A_1)+8 v(A_0)+6 v(Din_0)+4 v(Dout_0)+2 v(Dout_1) v(Dout_2)-2 v(Dout_3)-4 title 'SRAM Write/Read Validation'
.endc
.END
